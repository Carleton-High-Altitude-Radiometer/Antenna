# Ansys Electronics Desktop project, version 2017.0
materials:
  vacuum: permittivity=1

design Narrow_Horn (HFSS, DrivenModal, model units mm)
variables:
  Waveguide_Width = 5cm
  Antenna_Width = 30cm
  Waveguide_Height = Waveguide_Width/2
  Antenna_Height = Waveguide_Height*2
  Wall_Thickness = 5mm
geometry:
  Horn_Eplane_WR90_1 = component(Horn_Eplane_WR90, 3D_Component_File_Path=<syslib>/3DComponents/HFSS/Antennas/Waveguide/Horn_Eplane_WR90_DM.a3dcomp, a=Waveguide_Width, b=Waveguide_Height, Wall_Thickness=Wall_Thickness, WG_length=Waveguide_Width, FlareA=Antenna_Width, FlareB=Antenna_Height, Horn_length=Antenna_Width)
  WG_outer, Port_Cap [pec] = part_of(Horn_Eplane_WR90_1)
  port1 [vacuum] = part_of(Horn_Eplane_WR90_1)
  E_Plane_Bend1 = component(EPlaneBend, 3D_Component_File_Path="<syslib>/3DComponents/HFSS/Rectangular Waveguide/E_Plane_Bend.a3dcomp", WallThickness=Wall_Thickness, Flange=0cm, FlangeFillet=0.2cm, GuideWidth=Waveguide_Width, GuideHeight=Waveguide_Height, FlangeThickness=0.2cm, BendRadius=Waveguide_Width, BendAngle=90deg)
  EPB_Interior [vacuum] = part_of(E_Plane_Bend1)
  EPB [aluminum] = part_of(E_Plane_Bend1)
  E_Plane_Bend1.rotate(RotateAxis=X RotateAngle=90deg)
  E_Plane_Bend1.move(TranslateVectorX=0mm TranslateVectorY=50mm TranslateVectorZ=-39.5mm)
  E_Plane_Bend1.move(TranslateVectorX=0mm TranslateVectorY=2mm TranslateVectorZ=-67.5mm)
  E_Plane_Bend1.move(TranslateVectorX=0mm TranslateVectorY=0mm TranslateVectorZ=5mm)
  Straight1 = component(Straight, 3D_Component_File_Path="<syslib>/3DComponents/HFSS/Rectangular Waveguide/Straight.a3dcomp", WallThickness=Wall_Thickness, Flange=0in, FlangeFillet=0.2in, GuideWidth=Waveguide_Width, GuideHeight=Waveguide_Height, FlangeThickness=0.2in, GuideLength=20cm)
  WG_Interior [vacuum] = part_of(Straight1)
  WG [aluminum] = part_of(Straight1)
  Straight1.rotate(RotateAxis=X RotateAngle=90deg)
  Straight1.move(TranslateVectorX=0mm TranslateVectorY=252mm TranslateVectorZ=-102mm)
  Rectangle1 [vacuum] = rectangle(corner=(-30mm, 252mm, -119.5mm), z_size=35mm, x_size=60mm)
  Rectangle1.thicken(Wall_Thickness)
  Cylinder1 [vacuum] = cylinder(axis=Z, base_centre=(240mm, 0mm, 0mm), radius=10mm, height=-35mm)
  Cylinder1.move(-120mm, 0mm, 0mm)
  Cylinder1.move(-120mm, 220mm, 0mm)
  Cylinder1.move(10mm, 0mm, -120mm)
  Cylinder1.move(-10mm, 0mm, 0mm)
boundaries and excitations:
  Horn_Eplane_WR90_1_p1: Wave Port Objects=port1 NumModes=1 Modes{Mode1{IntLine{middle of port1.edge(#4317) -> middle of port1.edge(#4319)} CharImp=Zpv}}
  E_Plane_Bend1_2: Wave Port Faces=EPB_Interior.face(#4449) NumModes=1 Modes{Mode1{IntLine{middle of EPB_Interior.edge(#4464) -> middle of EPB_Interior.edge(#4466)} CharImp=Zpv}}
  E_Plane_Bend1_1: Wave Port Faces=EPB_Interior.face(#4452) NumModes=1 Modes{Mode1{IntLine{middle of EPB_Interior.edge(#4473) -> middle of EPB_Interior.edge(#4475)} CharImp=Zpv}}
  Straight1_2: Wave Port Faces=WG_Interior.face(#4920) NumModes=1 Modes{Mode1{IntLine{middle of WG_Interior.edge(#4926) -> middle of WG_Interior.edge(#4928)} CharImp=Zpv}}
  Straight1_1: Wave Port Faces=WG_Interior.face(#4921) NumModes=1 Modes{Mode1{IntLine{middle of WG_Interior.edge(#4930) -> middle of WG_Interior.edge(#4932)} CharImp=Zpv}}
source amplitudes:
  Horn_Eplane_WR90_1_p1:1: 1W 0deg
  E_Plane_Bend1_1:1, E_Plane_Bend1_2:1, Straight1_1:1, Straight1_2:1: 0W 0deg
