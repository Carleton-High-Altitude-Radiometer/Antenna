# Ansys Electronics Desktop project, version 2017.0
materials:
  vacuum: permittivity=1
  copper: permeability=0.999991 conductivity=58000000

design Narrow_Horn (HFSS, DrivenModal, model units mm)
variables:
  Waveguide_Width = 5cm
  Antenna_Width = 30cm
  Waveguide_Height = Waveguide_Width/2
  Antenna_Height = Waveguide_Height*2
  Wall_Thickness = 5mm
geometry:
  Horn_Eplane_WR90_1 = component(Horn_Eplane_WR90, 3D_Component_File_Path=<syslib>/3DComponents/HFSS/Antennas/Waveguide/Horn_Eplane_WR90_DM.a3dcomp, a=Waveguide_Width, b=Waveguide_Height, Wall_Thickness=Wall_Thickness, WG_length=Waveguide_Width, FlareA=Antenna_Width, FlareB=Antenna_Height, Horn_length=Antenna_Width)
  WG_outer, Port_Cap [pec] = part_of(Horn_Eplane_WR90_1)
  port1 [vacuum] = part_of(Horn_Eplane_WR90_1)
  E_Plane_Bend1 = component(EPlaneBend, 3D_Component_File_Path="<syslib>/3DComponents/HFSS/Rectangular Waveguide/E_Plane_Bend.a3dcomp", WallThickness=Wall_Thickness, Flange=0cm, FlangeFillet=0.2cm, GuideWidth=Waveguide_Width, GuideHeight=Waveguide_Height, FlangeThickness=0.2cm, BendRadius=Waveguide_Width, BendAngle=90deg)
  EPB_Interior [vacuum] = part_of(E_Plane_Bend1)
  EPB [aluminum] = part_of(E_Plane_Bend1)
  E_Plane_Bend1.rotate(RotateAxis=X RotateAngle=90deg)
  E_Plane_Bend1.move(TranslateVectorX=0mm TranslateVectorY=50mm TranslateVectorZ=-39.5mm)
  E_Plane_Bend1.move(TranslateVectorX=0mm TranslateVectorY=2mm TranslateVectorZ=-67.5mm)
  E_Plane_Bend1.move(TranslateVectorX=0mm TranslateVectorY=0mm TranslateVectorZ=5mm)
  Straight1 = component(Straight, 3D_Component_File_Path="<syslib>/3DComponents/HFSS/Rectangular Waveguide/Straight.a3dcomp", WallThickness=Wall_Thickness, Flange=0in, FlangeFillet=0.2in, GuideWidth=Waveguide_Width, GuideHeight=Waveguide_Height, FlangeThickness=0.2in, GuideLength=20cm)
  WG_Interior [vacuum] = part_of(Straight1)
  WG [aluminum] = part_of(Straight1)
  Straight1.rotate(RotateAxis=X RotateAngle=90deg)
  Straight1.move(TranslateVectorX=0mm TranslateVectorY=252mm TranslateVectorZ=-102mm)
  Rectangle1 [vacuum] = rectangle(corner=(-30mm, 252mm, -119.5mm), z_size=35mm, x_size=60mm)
  Rectangle1.thicken(Wall_Thickness)
  Cylinder1 [vacuum] = cylinder(axis=Z, base_centre=(240mm, 0mm, 0mm), radius=10mm, height=-35mm)
  Cylinder1.move(-120mm, 0mm, 0mm)
  Cylinder1.move(-120mm, 220mm, 0mm)
  Cylinder1.move(10mm, 0mm, -120mm)
  Cylinder1.move(-10mm, 0mm, 0mm)
  Cylinder2 [vacuum] = cylinder(axis=Z, base_centre=(240mm, 0mm, 0mm), radius=10mm, height=-35mm)
  Cylinder2.move(-120mm, 0mm, 0mm)
  Cylinder2.move(-120mm, 220mm, 0mm)
  Cylinder2.move(10mm, 0mm, -120mm)
  Cylinder2.move(-10mm, 0mm, 0mm)
  Cylinder2.rotate(axis=X, angle=90deg)
  Cylinder2.rotate(axis=Z, angle=90deg)
  Cylinder2.move(90mm, 190mm, 0mm)
  Cylinder2.move(1.4210855e-14mm, -10mm, -320mm)
boundaries and excitations:
  Horn_Eplane_WR90_1_p1: Wave Port Objects=port1 NumModes=1 Modes{Mode1{IntLine{middle of port1.edge(#4317) -> middle of port1.edge(#4319)} CharImp=Zpv}}
  E_Plane_Bend1_2: Wave Port Faces=EPB_Interior.face(#4449) NumModes=1 Modes{Mode1{IntLine{middle of EPB_Interior.edge(#4464) -> middle of EPB_Interior.edge(#4466)} CharImp=Zpv}}
  E_Plane_Bend1_1: Wave Port Faces=EPB_Interior.face(#4452) NumModes=1 Modes{Mode1{IntLine{middle of EPB_Interior.edge(#4473) -> middle of EPB_Interior.edge(#4475)} CharImp=Zpv}}
  Straight1_2: Wave Port Faces=WG_Interior.face(#4920) NumModes=1 Modes{Mode1{IntLine{middle of WG_Interior.edge(#4926) -> middle of WG_Interior.edge(#4928)} CharImp=Zpv}}
  Straight1_1: Wave Port Faces=WG_Interior.face(#4921) NumModes=1 Modes{Mode1{IntLine{middle of WG_Interior.edge(#4930) -> middle of WG_Interior.edge(#4932)} CharImp=Zpv}}
source amplitudes:
  Horn_Eplane_WR90_1_p1:1: 1W 0deg
  E_Plane_Bend1_1:1, E_Plane_Bend1_2:1, Straight1_1:1, Straight1_2:1: 0W 0deg

design Just_Horn (HFSS, DrivenModal, model units mm)
variables:
  Waveguide_Width = 5cm
  Wall_Thickness = 5mm
  Antenna_Width = 30cm
  Antenna_Height = Waveguide_Height*2
  Waveguide_Height = Waveguide_Width/2
geometry:
  Rectangle1 = rectangle(corner=(-Waveguide_Width/2, -Waveguide_Height/2, 0mm), x_size=Waveguide_Width, y_size=Waveguide_Height)
  Rectangle2 = rectangle(corner=(-Antenna_Width/2, -Antenna_Height/2, Antenna_Width), x_size=Antenna_Width, y_size=Antenna_Height)
  Polyline1 = polyline(xyz in mm: (25, 12.5, 0) (150, 25, 300) (150, -25, 300) (25, -12.5, 0) (25, 12.5, 0), closed, covered)
  Polyline2 = polyline(xyz in mm: (25, 12.5, 0) (-25, 12.5, 0) (-150, 25, 300) (150, 25, 300) (25, 12.5, 0), closed, covered)
  Polyline3 = polyline(xyz in mm: (-25, 12.5, 0) (-150, 25, 300) (-150, -25, 300) (-25, -12.5, 0) (-25, 12.5, 0), closed, covered)
  Polyline4 = polyline(xyz in mm: (-25, -12.5, 0) (25, -12.5, 0) (150, -25, 300) (-150, -25, 300) (-25, -12.5, 0), closed, covered)
  Box1 = box(corner=(-Waveguide_Width/2, -Waveguide_Height/2, 0cm), size=(Waveguide_Width, Waveguide_Height, -200mm))
  Box1_Detach1..Box1_Detach5 = Box1.detach(Box1.face(-z, -y, -x, +y, +x))
  Box1.delete()
  Box1_Detach1.unite(Box1_Detach2..Box1_Detach5, Polyline1..Polyline4, Rectangle1, Rectangle2)
boundaries and excitations:
  Rad1: Radiation Faces=Box1_Detach1.face
  Waveguide: Finite Conductivity Faces=Box1_Detach1.face(, , , , , , , ) UseMaterial Material=copper IsInternal
  1: Wave Port Faces=Box1_Detach1.face NumModes=2 Modes{Mode1{IntLine{middle of Box1_Detach1.edge(at (0, -12.5, -200)) -> middle of Box1_Detach1.edge(at (0, 12.5, -200))} CharImp=Zpi} Mode2{IntLine{middle of Box1_Detach1.edge(at (25, 0, -200)) -> middle of Box1_Detach1.edge(at (-25, 0, -200))} CharImp=Zpi}}
setups:
  Setup1: HfssDriven Frequency=7GHz MaxDeltaS=0.02 MaximumPasses=6 MinimumPasses=1 MinimumConvergedPasses=1 PercentRefinement=30 BasisOrder=1 PortAccuracy=2 RayDensityPerWavelength=4 MaxNumberOfBounces=5
source amplitudes:
  1:1: 1W 0deg
  1:2: 0W 0deg
radiation setups:
  Infinite Sphere1: Infinite Sphere Theta=0deg..360deg step 2deg Phi=0deg..360deg step 2deg
reports:
  3D Polar Plot 1: dB(GainTotal) vs Phi, Theta on Setup1 : LastAdaptive, Infinite Sphere1 [Freq=7GHz]
